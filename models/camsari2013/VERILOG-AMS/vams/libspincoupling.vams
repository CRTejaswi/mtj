/*********** libSpin: Library for Spintronics***************
 Library module of Magnet Coupling

Version 1.0.0alpha

Copyright @ 2014 Samiran Ganguly, Kerem Y. Camsari, Supriyo Datta Group, Purdue University

The terms under which the software and associated documentation (the Software) is provided are as the following:

The Software is provided "as is", without warranty of any kind, express or implied, including but not limited to the warranties of merchantability, fitness for a particular purpose and noninfringement. In no event shall the authors or copyright holders be liable for any claim, damages or other liability, whether in an action of contract, tort or otherwise, arising from, out of or in connection with the Software or the use or other dealings in the Software.

Samiran Ganguly and Kerem Y. Camsari, Supriyo Datta Group, Purdue University grants, free of charge, to any users the right to modify, copy, and redistribute the Software, both within the user's organization and externally, subject to the following restrictions:

1. The users agree not to charge for the code itself but may charge for additions, extensions, or support.

2. In any product based on the Software, the users agree to acknowledge the Research Group that developed the software. This acknowledgment shall appear in the product documentation.

3. The users agree to obey all U.S. Government restrictions governing redistribution or export of the software.

4. The users agree to reproduce any copyright notice which appears on the software on any copy or modification of such made available to others.

Agreed to by
Samiran Ganguly
Kerem Y. Camsari
September 2014
*************************************************************/
/*************************************************************
 The model:
    Hj = Kji*mi
    Where K in general is a matrix. Here we have implemented it as a diagonal matrix

 Circuit: A VCVS whose input in m and output is Km
**************************************************************/

`ifdef LIBSPINCOUPLING_VAMS
`else
`define LIBSPINCOUPLING_VAMS 1

module ls_coupling(m1x,m1y,m1z,m2x,m2y,m2z,h1x,h1y,h1z,h2x,h2y,h2z);

    input m1x,m1y,m1z,m2x,m2y,m2z;
    output h1x,h1y,h1z,h2x,h2y,h2z;
    electrical m1x,m1y,m1z,m2x,m2y,m2z,h1x,h1y,h1z,h2x,h2y,h2z;
    ground gnd;

    //All the coupling parameters - default is 0
    //Basic model is H = Km where K is a diagonal matrix
    parameter real K12_xx = 0 from (-inf:inf);
    parameter real K12_yy = 0 from (-inf:inf);
    parameter real K12_zz = 0 from (-inf:inf);
    parameter real K21_xx = 0 from (-inf:inf);
    parameter real K21_yy = 0 from (-inf:inf);
    parameter real K21_zz = 0 from (-inf:inf);

    //model is simple. The output is basically a VCVS, the controller being input "m"
    analog begin
        V(h2x,gnd) <+ K21_xx*V(m1x);
        V(h2y,gnd) <+ K21_yy*V(m1y);
        V(h2z,gnd) <+ K21_zz*V(m1z);
        V(h1x,gnd) <+ K12_xx*V(m2x);
        V(h1y,gnd) <+ K12_yy*V(m2y);
        V(h1z,gnd) <+ K12_zz*V(m2z);
    end

endmodule

`endif
