/*********** libSpin: Library for Spintronics***************
 Library module of a generic 4-component resistor

 Version 1.0.0alpha

 Copyright @ 2014 Samiran Ganguly, Kerem Y. Camsari, Supriyo Datta Group, Purdue University

 The terms under which the software and associated documentation (the Software) is provided are as the following:

 The Software is provided "as is", without warranty of any kind, express or implied, including but not limited to the warranties of merchantability, fitness for a particular purpose and noninfringement. In no event shall the authors or copyright holders be liable for any claim, damages or other liability, whether in an action of contract, tort or otherwise, arising from, out of or in connection with the Software or the use or other dealings in the Software.

 Samiran Ganguly and Kerem Y. Camsari, Supriyo Datta Group, Purdue University grants, free of charge, to any users the right to modify, copy, and redistribute the Software, both within the user's organization and externally, subject to the following restrictions:

 1. The users agree not to charge for the code itself but may charge for additions, extensions, or support.

 2. In any product based on the Software, the users agree to acknowledge the Research Group that developed the software. This acknowledgment shall appear in the product documentation.

 3. The users agree to obey all U.S. Government restrictions governing redistribution or export of the software.

 4. The users agree to reproduce any copyright notice which appears on the software on any copy or modification of such made available to others.

 Agreed to by
 Samiran Ganguly
 Kerem Y. Camsari
 September 2014
*************************************************************/
/************************************************************

A simple 4-component resistor - use for diagnostic purposes
DO NOT USE IN REAL MODELS - USE NM INSTEAD

*************************************************************/

`ifdef LIBSPINRES_VAMS
`else
`define LIBSPINRES_VAMS 1

module ls_res(pc,px,py,pz,nc,nx,ny,nz);

    inout pc,px,py,pz,nc,nx,ny,nz;
    electrical pc,px,py,pz,nc,nx,ny,nz;

    parameter real gc=0.0;
    parameter real gx=0.0;
    parameter real gy=0.0;
    parameter real gz=0.0;

    analog begin

        I(pc,nc) <+ V(pc,nc)*gc;
        I(px,nx) <+ V(px,nx)*gx;
        I(py,ny) <+ V(py,ny)*gy;
        I(pz,nz) <+ V(pz,nz)*gz;

    end

endmodule

`endif
