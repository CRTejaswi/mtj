// Creator: Harsha Choday
// Email: schoday@purdue.edu
// Contributors: Xuanyao Fong
// This file is a copy of MTJ_QCOM5_res.va with added comment lines
// Resistance model of MTJ with physical params:
// Eb=0.8, delta=0.75, m_fm=0.735, m_ox=0.74, Ms=800, Ku2=30000
// This file and the coefficients for fitting equation generated by MATLAB

`include "disciplines.vams"
`include "constants.vams"

module MTJ_res(t1,t2,MTJ_curr,th,phi,th_hard,phi_hard);
inout t1,t2;
input th,phi,th_hard,phi_hard;
output MTJ_curr;
electrical t1,t2,MTJ_curr,th,phi,th_hard,phi_hard; //External Terminals of the resistor

// Coefficients for fitting Rap
parameter real c1_ap = -6.7524 from (-inf:inf);
parameter real c2_ap = 23.2848 from (-inf:inf);
parameter real c3_ap = -7.56891 from (-inf:inf);
parameter real c4_ap = 24.144 from (-inf:inf);
parameter real c5_p = 1 from (-inf:inf);

// Coefficients for fitting Rp
parameter real c1_p = -5.90497 from (-inf:inf);
parameter real c2_p = 21.5434 from (-inf:inf);
parameter real c3_p = -7.46919 from (-inf:inf);
parameter real c4_p = 25.0243 from (-inf:inf);
parameter real c5_ap = 1 from (-inf:inf);

parameter real Tox = 1.15 from (-inf:inf);
parameter real Area = 3.6298e-15 from (-inf:inf); // 0.25*3.14*2.89*40e-9*40e-9 m2
(* desc="MTJ Resistances", units="Ohm" *) real Gp, Gap, Gmtj, Rmtj, mdp;

analog begin : res_module

	real Gp_pre, Gap_pre;

	mdp = (sin(V(th))*cos(V(th))*sin(V(th_hard))*cos(V(phi_hard))) + (sin(V(th))*sin(V(phi))*sin(V(th_hard))*sin(V(phi_hard))) + (cos(V(th))*cos(V(th_hard)));

	Gp_pre = exp(c1_p*Tox + c2_p)*pow(V(t1,t2),2) + exp(c3_p*Tox + c4_p); // Polynomial gives G/A
	Gap_pre = exp(c1_ap*Tox + c2_ap)*pow(V(t1,t2),2) + exp(c3_ap*Tox + c4_ap);

	Gp = (pow(Gp_pre,1))*(Area*1e4); // Apply term_pow and multiply area to obtain conductance
	Gap = (pow(Gap_pre,1))*(Area*1e4);

	Gmtj = Gap + (mdp+1)*0.5*(Gp-Gap);
	Rmtj = pow(Gmtj,-1);

	I(t1,t2) <+ V(t1,t2)/Rmtj;
	V(MTJ_curr) <+ -V(t2,t1)/Rmtj;
end

endmodule
